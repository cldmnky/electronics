* MIDI IN at the nominal 5 V Type A sender and the TLP2361 threshold.
* is_led = 6.08e-16 gives VF = 1.50 V at 2 mA (datasheet typical 1.50 V).
* Design check only, not a hardware qualification.
.param vsrc = 5.0
.param ifhl = 1.3m
.param is_led = 6.08e-16
.include midi_in_common.inc
